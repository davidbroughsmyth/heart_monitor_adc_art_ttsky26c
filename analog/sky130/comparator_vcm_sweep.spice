* cmp with external vcm
.subckt comparator vhold vdac gnd vdd sample sample_b cmp_out
Xc1 vp n1 sky130_fd_pr__cap_mim_m3_1 W=16 L=16 mf=1
Xc2 vm n2 sky130_fd_pr__cap_mim_m3_1 W=16 L=16 mf=1
Xaz_b1n n1 sample   vcm gnd sky130_fd_pr__nfet_01v8 W=0.36 L=0.15
Xaz_b1p n1 sample_b vcm vdd sky130_fd_pr__pfet_01v8 W=0.72 L=0.15
Xaz_b2n n2 sample   vcm gnd sky130_fd_pr__nfet_01v8 W=0.36 L=0.15
Xaz_b2p n2 sample_b vcm vdd sky130_fd_pr__pfet_01v8 W=0.72 L=0.15
Xazn vp sample   vm gnd sky130_fd_pr__nfet_01v8 W=0.36 L=0.15
Xazp vp sample_b vm vdd sky130_fd_pr__pfet_01v8 W=0.72 L=0.15
Xsig_1n n1 sample_b vhold gnd sky130_fd_pr__nfet_01v8 W=0.36 L=0.15
Xsig_1p n1 sample   vhold vdd sky130_fd_pr__pfet_01v8 W=0.72 L=0.15
Xsig_2n n2 sample_b vdac  gnd sky130_fd_pr__nfet_01v8 W=0.36 L=0.15
Xsig_2p n2 sample   vdac  vdd sky130_fd_pr__pfet_01v8 W=0.72 L=0.15
Xbp nbias nbias vdd vdd sky130_fd_pr__pfet_01v8 W=0.84 L=1.0
Xbn nbias nbias gnd gnd sky130_fd_pr__nfet_01v8 W=0.84 L=1.0
Xtail tail nbias gnd gnd sky130_fd_pr__nfet_01v8 W=3.0 L=0.15
Xn1 d1 vp  tail gnd sky130_fd_pr__nfet_01v8 W=1.15 L=0.15
Xn2 d2 vm  tail gnd sky130_fd_pr__nfet_01v8 W=2.85 L=0.15
Xp1 d1 d1 vdd vdd sky130_fd_pr__pfet_01v8 W=1.72 L=0.15
Xp2 d2 d1 vdd vdd sky130_fd_pr__pfet_01v8 W=4.28 L=0.15
Xi0n mid d2 gnd gnd sky130_fd_pr__nfet_01v8 W=1.0 L=0.15
Xi0p mid d2 vdd vdd sky130_fd_pr__pfet_01v8 W=2.0 L=0.15
Xi1n cmp_out mid gnd gnd sky130_fd_pr__nfet_01v8 W=0.84 L=0.15
Xi1p cmp_out mid vdd vdd sky130_fd_pr__pfet_01v8 W=1.68 L=0.15
.ends comparator
