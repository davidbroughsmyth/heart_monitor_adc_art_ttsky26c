* sar_afe.spice — sky130 AFE: S/H + R-2R DAC + autozeroed comparator
* One shared sample / sample_b invert drives S/H TG and comparator AZ.

.include sample_hold.spice
.include cdac_12b.spice
.include comparator.spice

.subckt sar_afe vin_ecg vref gnd vdd sample
+ b11 b10 b9 b8 b7 b6 b5 b4 b3 b2 b1 b0
+ cmp_out

Xinv_pd sample_b sample gnd gnd sky130_fd_pr__nfet_01v8 W=0.42 L=0.15
Xinv_pu sample_b sample vdd vdd sky130_fd_pr__pfet_01v8 W=0.84 L=0.15

Xsh vin_ecg sample sample_b gnd vdd vhold sample_hold
Xdac vref gnd vdd vdac
+ b11 b10 b9 b8 b7 b6 b5 b4 b3 b2 b1 b0 cdac_12b
Xcmp vhold vdac gnd vdd sample sample_b cmp_out comparator

.ends sar_afe
