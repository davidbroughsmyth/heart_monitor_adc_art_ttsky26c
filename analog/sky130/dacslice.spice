* dacslice.spice — one R-2R bit slice (LVS reference for mag/afe_slice.tcl).
* Unit R (extracted l=9.08 for drawn 8.0); 2R = two series units.
* Wide TGs so Ron ≪ R.

.subckt tg a b en enb gnd vdd
Xn a en b gnd sky130_fd_pr__nfet_01v8 W=8.0 L=0.15
Xp a enb b vdd sky130_fd_pr__pfet_01v8 W=16.0 L=0.15
.ends tg

.subckt bit_drive bit bitb gnd vdd
Xn bitb bit gnd gnd sky130_fd_pr__nfet_01v8 W=0.42 L=0.15
Xp bitb bit vdd vdd sky130_fd_pr__pfet_01v8 W=0.84 L=0.15
.ends bit_drive

.subckt dacslice bit vref gnd vdd node nout
Xdb bit bitb gnd vdd bit_drive
Xtr snk vref bit  bitb gnd vdd tg
Xtg snk gnd  bitb bit  gnd vdd tg
XR2a snk mid gnd sky130_fd_pr__res_xhigh_po_0p35 l=9.08
XR2b mid node gnd sky130_fd_pr__res_xhigh_po_0p35 l=9.08
XR  nout node gnd sky130_fd_pr__res_xhigh_po_0p35 l=9.08
.ends dacslice
