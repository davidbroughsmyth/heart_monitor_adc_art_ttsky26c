* sample_hold.spice — sky130 TG + ~1 pF MIM hold
* sample high (1.8 V) = track; low = hold.
* sample_b is supplied by the parent (shared with comparator AZ).

.subckt sample_hold vin sample sample_b gnd vdd vhold
* CMOS transmission gate
Xtn vhold sample vin gnd sky130_fd_pr__nfet_01v8 W=1.0 L=0.15
Xtp vhold sample_b vin vdd sky130_fd_pr__pfet_01v8 W=2.0 L=0.15

* Hold capacitor (~1 pF MiM)
Xchold vhold gnd sky130_fd_pr__cap_mim_m3_1 W=22 L=22 mf=1
.ends sample_hold
