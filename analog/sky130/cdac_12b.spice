* cdac_12b.spice — R-2R ladder DAC with sky130 TG switches (best-effort)
* Electrically correct for polarity sims; layout may use poly/MOM later.

.subckt tg a b en enb gnd vdd
Xn a en b gnd sky130_fd_pr__nfet_01v8 W=1.0 L=0.15
Xp a enb b vdd sky130_fd_pr__pfet_01v8 W=2.0 L=0.15
.ends tg

.subckt bit_drive bit bitb gnd vdd
Xn bitb bit gnd gnd sky130_fd_pr__nfet_01v8 W=0.42 L=0.15
Xp bitb bit vdd vdd sky130_fd_pr__pfet_01v8 W=0.84 L=0.15
.ends bit_drive

.subckt cdac_12b vref gnd vdd dac_out
+ b11 b10 b9 b8 b7 b6 b5 b4 b3 b2 b1 b0

* Inverts
Xdb0 b0 b0b gnd vdd bit_drive
Xdb1 b1 b1b gnd vdd bit_drive
Xdb2 b2 b2b gnd vdd bit_drive
Xdb3 b3 b3b gnd vdd bit_drive
Xdb4 b4 b4b gnd vdd bit_drive
Xdb5 b5 b5b gnd vdd bit_drive
Xdb6 b6 b6b gnd vdd bit_drive
Xdb7 b7 b7b gnd vdd bit_drive
Xdb8 b8 b8b gnd vdd bit_drive
Xdb9 b9 b9b gnd vdd bit_drive
Xdb10 b10 b10b gnd vdd bit_drive
Xdb11 b11 b11b gnd vdd bit_drive

* Each bit selects vref or gnd into ladder node snk_i
Xt0r snk0 vref b0 b0b gnd vdd tg
Xt0g snk0 gnd  b0b b0  gnd vdd tg
Xt1r snk1 vref b1 b1b gnd vdd tg
Xt1g snk1 gnd  b1b b1  gnd vdd tg
Xt2r snk2 vref b2 b2b gnd vdd tg
Xt2g snk2 gnd  b2b b2  gnd vdd tg
Xt3r snk3 vref b3 b3b gnd vdd tg
Xt3g snk3 gnd  b3b b3  gnd vdd tg
Xt4r snk4 vref b4 b4b gnd vdd tg
Xt4g snk4 gnd  b4b b4  gnd vdd tg
Xt5r snk5 vref b5 b5b gnd vdd tg
Xt5g snk5 gnd  b5b b5  gnd vdd tg
Xt6r snk6 vref b6 b6b gnd vdd tg
Xt6g snk6 gnd  b6b b6  gnd vdd tg
Xt7r snk7 vref b7 b7b gnd vdd tg
Xt7g snk7 gnd  b7b b7  gnd vdd tg
Xt8r snk8 vref b8 b8b gnd vdd tg
Xt8g snk8 gnd  b8b b8  gnd vdd tg
Xt9r snk9 vref b9 b9b gnd vdd tg
Xt9g snk9 gnd  b9b b9  gnd vdd tg
Xt10r snk10 vref b10 b10b gnd vdd tg
Xt10g snk10 gnd  b10b b10 gnd vdd tg
Xt11r snk11 vref b11 b11b gnd vdd tg
Xt11g snk11 gnd  b11b b11 gnd vdd tg

* R-2R ladder (R=10k). snk11 = MSB near dac_out.
* Topology: dac_out -- R -- n10 -- R -- n9 ... -- R -- n0 -- 2R -- gnd
*           each snk_i -- 2R -- node
Rterm n0 gnd 20k
R2_0 snk0 n0 20k
R0 n0 n1 10k
R2_1 snk1 n1 20k
R1 n1 n2 10k
R2_2 snk2 n2 20k
R2 n2 n3 10k
R2_3 snk3 n3 20k
R3 n3 n4 10k
R2_4 snk4 n4 20k
R4 n4 n5 10k
R2_5 snk5 n5 20k
R5 n5 n6 10k
R2_6 snk6 n6 20k
R6 n6 n7 10k
R2_7 snk7 n7 20k
R7 n7 n8 10k
R2_8 snk8 n8 20k
R8 n8 n9 10k
R2_9 snk9 n9 20k
R9 n9 n10 10k
R2_10 snk10 n10 20k
R10 n10 dac_out 10k
R2_11 snk11 dac_out 20k

.ends cdac_12b
