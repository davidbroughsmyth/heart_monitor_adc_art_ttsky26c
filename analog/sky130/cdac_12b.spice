* cdac_12b.spice — R-2R ladder DAC, unit-based poly resistors + low-Ron TGs
* Unit R: drawn-length-matched sky130_fd_pr__res_xhigh_po_0p35 (rho=2000).
* True 2R = two series units (ratio by construction). Guard rings → gnd.
* Drawn length ~16 → extracted l≈9.08 (same shrink as prior 1.75→1.59).

.subckt tg a b en enb gnd vdd
Xn a en b gnd sky130_fd_pr__nfet_01v8 W=8.0 L=0.15
Xp a enb b vdd sky130_fd_pr__pfet_01v8 W=16.0 L=0.15
.ends tg

.subckt bit_drive bit bitb gnd vdd
Xn bitb bit gnd gnd sky130_fd_pr__nfet_01v8 W=0.42 L=0.15
Xp bitb bit vdd vdd sky130_fd_pr__pfet_01v8 W=0.84 L=0.15
.ends bit_drive

.subckt cdac_12b vref gnd vdd dac_out
+ b11 b10 b9 b8 b7 b6 b5 b4 b3 b2 b1 b0

* Inverts
Xdb0 b0 b0b gnd vdd bit_drive
Xdb1 b1 b1b gnd vdd bit_drive
Xdb2 b2 b2b gnd vdd bit_drive
Xdb3 b3 b3b gnd vdd bit_drive
Xdb4 b4 b4b gnd vdd bit_drive
Xdb5 b5 b5b gnd vdd bit_drive
Xdb6 b6 b6b gnd vdd bit_drive
Xdb7 b7 b7b gnd vdd bit_drive
Xdb8 b8 b8b gnd vdd bit_drive
Xdb9 b9 b9b gnd vdd bit_drive
Xdb10 b10 b10b gnd vdd bit_drive
Xdb11 b11 b11b gnd vdd bit_drive

* Each bit selects vref or gnd into ladder node snk_i (wide TGs, Ron ≪ R)
Xt0r snk0 vref b0 b0b gnd vdd tg
Xt0g snk0 gnd  b0b b0  gnd vdd tg
Xt1r snk1 vref b1 b1b gnd vdd tg
Xt1g snk1 gnd  b1b b1  gnd vdd tg
Xt2r snk2 vref b2 b2b gnd vdd tg
Xt2g snk2 gnd  b2b b2  gnd vdd tg
Xt3r snk3 vref b3 b3b gnd vdd tg
Xt3g snk3 gnd  b3b b3  gnd vdd tg
Xt4r snk4 vref b4 b4b gnd vdd tg
Xt4g snk4 gnd  b4b b4  gnd vdd tg
Xt5r snk5 vref b5 b5b gnd vdd tg
Xt5g snk5 gnd  b5b b5  gnd vdd tg
Xt6r snk6 vref b6 b6b gnd vdd tg
Xt6g snk6 gnd  b6b b6  gnd vdd tg
Xt7r snk7 vref b7 b7b gnd vdd tg
Xt7g snk7 gnd  b7b b7  gnd vdd tg
Xt8r snk8 vref b8 b8b gnd vdd tg
Xt8g snk8 gnd  b8b b8  gnd vdd tg
Xt9r snk9 vref b9 b9b gnd vdd tg
Xt9g snk9 gnd  b9b b9  gnd vdd tg
Xt10r snk10 vref b10 b10b gnd vdd tg
Xt10g snk10 gnd  b10b b10 gnd vdd tg
Xt11r snk11 vref b11 b11b gnd vdd tg
Xt11g snk11 gnd  b11b b11 gnd vdd tg

* Unit resistance length (extracted-equivalent for drawn l≈10)
* Topology: dac_out -- R -- n10 -- R -- … -- R -- n0 -- 2R -- gnd
*           each snk_i -- 2R(=R+R) -- node
XRterm_a n0 mterm gnd sky130_fd_pr__res_xhigh_po_0p35 l=9.08
XRterm_b mterm gnd gnd sky130_fd_pr__res_xhigh_po_0p35 l=9.08

XR2_0a snk0 m0 gnd sky130_fd_pr__res_xhigh_po_0p35 l=9.08
XR2_0b m0 n0 gnd sky130_fd_pr__res_xhigh_po_0p35 l=9.08
XR0 n0 n1 gnd sky130_fd_pr__res_xhigh_po_0p35 l=9.08

XR2_1a snk1 m1 gnd sky130_fd_pr__res_xhigh_po_0p35 l=9.08
XR2_1b m1 n1 gnd sky130_fd_pr__res_xhigh_po_0p35 l=9.08
XR1 n1 n2 gnd sky130_fd_pr__res_xhigh_po_0p35 l=9.08

XR2_2a snk2 m2 gnd sky130_fd_pr__res_xhigh_po_0p35 l=9.08
XR2_2b m2 n2 gnd sky130_fd_pr__res_xhigh_po_0p35 l=9.08
XR2 n2 n3 gnd sky130_fd_pr__res_xhigh_po_0p35 l=9.08

XR2_3a snk3 m3 gnd sky130_fd_pr__res_xhigh_po_0p35 l=9.08
XR2_3b m3 n3 gnd sky130_fd_pr__res_xhigh_po_0p35 l=9.08
XR3 n3 n4 gnd sky130_fd_pr__res_xhigh_po_0p35 l=9.08

XR2_4a snk4 m4 gnd sky130_fd_pr__res_xhigh_po_0p35 l=9.08
XR2_4b m4 n4 gnd sky130_fd_pr__res_xhigh_po_0p35 l=9.08
XR4 n4 n5 gnd sky130_fd_pr__res_xhigh_po_0p35 l=9.08

XR2_5a snk5 m5 gnd sky130_fd_pr__res_xhigh_po_0p35 l=9.08
XR2_5b m5 n5 gnd sky130_fd_pr__res_xhigh_po_0p35 l=9.08
XR5 n5 n6 gnd sky130_fd_pr__res_xhigh_po_0p35 l=9.08

XR2_6a snk6 m6 gnd sky130_fd_pr__res_xhigh_po_0p35 l=9.08
XR2_6b m6 n6 gnd sky130_fd_pr__res_xhigh_po_0p35 l=9.08
XR6 n6 n7 gnd sky130_fd_pr__res_xhigh_po_0p35 l=9.08

XR2_7a snk7 m7 gnd sky130_fd_pr__res_xhigh_po_0p35 l=9.08
XR2_7b m7 n7 gnd sky130_fd_pr__res_xhigh_po_0p35 l=9.08
XR7 n7 n8 gnd sky130_fd_pr__res_xhigh_po_0p35 l=9.08

XR2_8a snk8 m8 gnd sky130_fd_pr__res_xhigh_po_0p35 l=9.08
XR2_8b m8 n8 gnd sky130_fd_pr__res_xhigh_po_0p35 l=9.08
XR8 n8 n9 gnd sky130_fd_pr__res_xhigh_po_0p35 l=9.08

XR2_9a snk9 m9 gnd sky130_fd_pr__res_xhigh_po_0p35 l=9.08
XR2_9b m9 n9 gnd sky130_fd_pr__res_xhigh_po_0p35 l=9.08
XR9 n9 n10 gnd sky130_fd_pr__res_xhigh_po_0p35 l=9.08

XR2_10a snk10 m10 gnd sky130_fd_pr__res_xhigh_po_0p35 l=9.08
XR2_10b m10 n10 gnd sky130_fd_pr__res_xhigh_po_0p35 l=9.08
XR10 n10 dac_out gnd sky130_fd_pr__res_xhigh_po_0p35 l=9.08

XR2_11a snk11 m11 gnd sky130_fd_pr__res_xhigh_po_0p35 l=9.08
XR2_11b m11 dac_out gnd sky130_fd_pr__res_xhigh_po_0p35 l=9.08

.ends cdac_12b
